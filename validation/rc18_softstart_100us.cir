* RC18 Rev.B-SI — 100 us average-output soft-start check
V5 a5 0 PWL(0 0 1u 0 101u 6 150u 6)
C5 a5 c5x 1.05u
VS5 c5x c5 0
R305 c5 s5 5.126
RL5 s5 0 5
V10 a10 0 PWL(0 0 1u 0 101u 6 150u 6)
C10 a10 c10x 1.05u
VS10 c10x c10 0
R3010 c10 s10 5.126
RL10 s10 0 10
V20 a20 0 PWL(0 0 1u 0 101u 6 150u 6)
C20 a20 c20x 1.05u
VS20 c20x c20 0
R3020 c20 s20 5.126
RL20 s20 0 20
.tran 50n 180u 0 50n
.meas tran I5_MAX MAX I(VS5)
.meas tran I10_MAX MAX I(VS10)
.meas tran I20_MAX MAX I(VS20)
.end
